// =============================================================================
// Process-Independent Fully Differential OTA TB — CMRR, PSRR+, PSRR- & Noise
// =============================================================================
// Instantiates four matched FD-OTA replicas (with external CMFB resistive sense)
// to measure all differential and common-mode rejection metrics in one AC+noise
// run:
//   - I_DM : Open-loop differential DC-servo replica (1 Gohm + 1 F -> 0.16 nHz)
//            -> A_DM(f) and exact differential input-referred `noise` (via single
//            source VSRC_DM feeding +/-0.5 VCVS splitter so iprobe=VSRC_DM is exact)
//   - I_CM : Closed-loop inverting (-1) bridge driven by AC 1 V common-mode
//            -> A_cm_cm(f) = 0.5*(VOP_CM+VON_CM) and CMRR_dm(f) = 1/|VOP_CM-VON_CM|
//   - I_PP : Closed-loop (-1) with AC 1 V on VDD -> PSRR+(VDD->CM & VDD->DM)
//   - I_PN : Closed-loop (-1) with AC 1 V on VSS -> PSRR-(VSS->CM & VSS->DM)
//
// DUT interface contract:
//   subckt dut_fd_ota VIP VIN VOCM VCM_FB VOP VON VDD VSS
// =============================================================================

simulator lang=spectre
global 0

include "models_corner.scs"
include "dut_subckt.scs"

parameters \
    vdd=0.9 \
    vocm=0.45 \
    cload=2p \
    rload=1M \
    rf=100k \
    rcm=500k \
    temp_c=27

VVOCM (VOCM 0) vsource dc=vocm type=dc

// ── 1. Open-loop differential reference & input-referred noise ───────────────
VSUP_DM (VDD_DM 0) vsource dc=vdd type=dc
VGND_DM (VSS_DM 0) vsource dc=0   type=dc
VSRC_DM (N_SRC  0) vsource dc=0   mag=1 type=dc
EVIP_DM (VIP_DM    VOCM N_SRC 0) vcvs gain=0.5
EVIN_DM (VIN_DM_AC 0    N_SRC 0) vcvs gain=-0.5
// Purely differential DC servo (keeps VOP_DM == VON_DM at DC, open at f >= 1 Hz)
ESRV_DM (N_SRV_DM VOCM VOP_DM VON_DM) vcvs gain=0.5
RSRV_DM (N_SRV_DM VIN_DM)    resistor  r=1G
CSRV_DM (VIN_DM   VIN_DM_AC) capacitor c=1.0

I_DM    (VIP_DM VIN_DM VOCM VCMFB_DM VOP_DM VON_DM VDD_DM VSS_DM) dut_fd_ota
RCMP_DM (VOP_DM VCMFB_DM) resistor  r=rcm
RCMN_DM (VON_DM VCMFB_DM) resistor  r=rcm
CLP_DM  (VOP_DM VSS_DM)   capacitor c=cload
CLN_DM  (VON_DM VSS_DM)   capacitor c=cload
RLP_DM  (VOP_DM VOCM)     resistor  r=rload
RLN_DM  (VON_DM VOCM)     resistor  r=rload

// ── 2. Closed-loop (-1) Common-Mode stimulus (CM->CM & CM->DM) ───────────────
VSUP_CM (VDD_CM 0) vsource dc=vdd type=dc
VGND_CM (VSS_CM 0) vsource dc=0   type=dc
VCM_IN  (IN_CM  0) vsource dc=vocm mag=1 type=dc
RGP_CM  (IN_CM  VIN_CM) resistor r=rf
RGN_CM  (IN_CM  VIP_CM) resistor r=rf
RFP_CM  (VOP_CM VIN_CM) resistor r=rf
RFN_CM  (VON_CM VIP_CM) resistor r=rf

I_CM    (VIP_CM VIN_CM VOCM VCMFB_CM VOP_CM VON_CM VDD_CM VSS_CM) dut_fd_ota
RCMP_CM (VOP_CM VCMFB_CM) resistor  r=rcm
RCMN_CM (VON_CM VCMFB_CM) resistor  r=rcm
CLP_CM  (VOP_CM VSS_CM)   capacitor c=cload
CLN_CM  (VON_CM VSS_CM)   capacitor c=cload
RLP_CM  (VOP_CM VOCM)     resistor  r=rload
RLN_CM  (VON_CM VOCM)     resistor  r=rload

// ── 3. Closed-loop (-1) PSRR+ (AC 1 V on VDD) ────────────────────────────────
VSUP_PP (VDD_PP 0) vsource dc=vdd mag=1 type=dc
VGND_PP (VSS_PP 0) vsource dc=0         type=dc
RGP_PP  (VOCM   VIN_PP) resistor r=rf
RGN_PP  (VOCM   VIP_PP) resistor r=rf
RFP_PP  (VOP_PP VIN_PP) resistor r=rf
RFN_PP  (VON_PP VIP_PP) resistor r=rf

I_PP    (VIP_PP VIN_PP VOCM VCMFB_PP VOP_PP VON_PP VDD_PP VSS_PP) dut_fd_ota
RCMP_PP (VOP_PP VCMFB_PP) resistor  r=rcm
RCMN_PP (VON_PP VCMFB_PP) resistor  r=rcm
CLP_PP  (VOP_PP 0)        capacitor c=cload
CLN_PP  (VON_PP 0)        capacitor c=cload
RLP_PP  (VOP_PP VOCM)     resistor  r=rload
RLN_PP  (VON_PP VOCM)     resistor  r=rload

// ── 4. Closed-loop (-1) PSRR- (AC 1 V on VSS) ────────────────────────────────
VSUP_PN (VDD_PN 0) vsource dc=vdd       type=dc
VGND_PN (VSS_PN 0) vsource dc=0   mag=1 type=dc
RGP_PN  (VOCM   VIN_PN) resistor r=rf
RGN_PN  (VOCM   VIP_PN) resistor r=rf
RFP_PN  (VOP_PN VIN_PN) resistor r=rf
RFN_PN  (VON_PN VIP_PN) resistor r=rf

I_PN    (VIP_PN VIN_PN VOCM VCMFB_PN VOP_PN VON_PN VDD_PN VSS_PN) dut_fd_ota
RCMP_PN (VOP_PN VCMFB_PN) resistor  r=rcm
RCMN_PN (VON_PN VCMFB_PN) resistor  r=rcm
CLP_PN  (VOP_PN 0)        capacitor c=cload
CLN_PN  (VON_PN 0)        capacitor c=cload
RLP_PN  (VOP_PN VOCM)     resistor  r=rload
RLN_PN  (VON_PN VOCM)     resistor  r=rload

simulatorOptions options psfversion="1.4.0" \
    reltol=1e-4 vabstol=1e-7 iabstol=1e-13 \
    temp=temp_c tnom=27 gmin=1e-12 rforce=1 maxnotes=5 maxwarns=5

ac    ac start=1 stop=1G dec=20 annotate=status
noise (VOP_DM VON_DM) noise start=1 stop=1G dec=20 iprobe=VSRC_DM annotate=status

save VOP_DM VON_DM VOP_CM VON_CM VOP_PP VON_PP VOP_PN VON_PN
saveOptions options save=selected
