// =============================================================================
// Process-Independent Single-Ended OpAmp/OTA TB — Loop Stability (`stb`) & DC
// =============================================================================
// Measures closed-loop stability (default unity gain beta=1; adjust rf/rg for
// non-unity feedback) using Spectre `stb` (`iprobe`) without disturbing DC bias
// or output capacitive loading:
//   - DC open-loop gain A0 [dB], UGF [MHz], Phase Margin PM [deg], Gain Margin GM [dB]
//   - Quiescent supply current I_DD [uA], DC power P_DC [mW], Small-Signal FoM_S
//
// DUT interface contract (5-pin single-ended OpAmp/OTA):
//   subckt dut_ota VIP VIN VOUT VDD VSS
// =============================================================================

simulator lang=spectre
global 0

include "models_corner.scs"
include "dut_subckt.scs"

parameters \
    vdd=0.9 \
    vcm=0.45 \
    cload=2p \
    rload=100M \
    temp_c=27

VSUP (VDD 0) vsource dc=vdd type=dc
VGND (VSS 0) vsource dc=0   type=dc
VVCM (VIP 0) vsource dc=vcm type=dc

I0   (VIP VIN VOUT VDD VSS) dut_ota
IPRB (VOUT VIN) iprobe

CL   (VOUT VSS) capacitor c=cload
RL   (VOUT VSS) resistor  r=rload

simulatorOptions options psfversion="1.4.0" \
    reltol=1e-4 vabstol=1e-7 iabstol=1e-13 \
    temp=temp_c tnom=27 gmin=1e-12 rforce=1 maxnotes=5 maxwarns=5

dc  dc
stb stb start=1 stop=10G dec=20 probe=IPRB annotate=status

save VOUT VSUP:p
saveOptions options save=selected
