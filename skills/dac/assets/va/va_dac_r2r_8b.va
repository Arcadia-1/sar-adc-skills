// Process-independent 8-bit Voltage-Mode R-2R Ladder DAC Behavioral Model
//
// Models the exact Thevenin equivalent of an 8-bit voltage-mode R-2R ladder:
//   - Open-circuit voltage V_th(code) = VREF * sum(w_i * b_i) / 256
//   - Constant ladder output resistance R_out = r_unit + r_sw (independent of code!)
//   - Injectable MSB (bit 7) 2R-branch mismatch `dm_msb` demonstrating the classic
//     R-2R major-carry DNL/INL discontinuity at code 127 -> 128
//   - Smooth switch transition edge `t_edge` and parasitic output cap `c_out`

`include "constants.vams"
`include "disciplines.vams"

module va_dac_r2r_8b(
    input  electrical [7:0] DIN,
    input  electrical       VREF,
    input  electrical       VSS,
    output electrical       VOUT
);

parameter real vth    = 0.50   from (0:inf);     // digital threshold [V]
parameter real r_unit = 10e3   from (10:1e8);    // R-2R unit resistance R [ohm]
parameter real r_sw   = 200.0  from [0:1e6);     // switch ON-resistance contribution [ohm]
parameter real dm_msb = 0.0;                     // fractional MSB 2R mismatch (e.g. 0.01 -> +1.28 LSB step)
parameter real t_edge = 100e-12 from (1e-12:inf);// switch transition time [s]
parameter real c_out  = 50e-15 from [0:inf);     // internal ladder output parasitic cap [F]

real w_sum, w_smooth, v_th_oc, r_eff;
genvar i;

analog begin
    w_sum = 0.0;
    for (i = 0; i < 7; i = i + 1) begin
        if (V(DIN[i], VSS) > vth)
            w_sum = w_sum + pow(2.0, i);
    end
    if (V(DIN[7], VSS) > vth)
        w_sum = w_sum + 128.0 * (1.0 + dm_msb);

    w_smooth = transition(w_sum / 256.0, 0.0, t_edge, t_edge);
    v_th_oc  = V(VREF, VSS) * w_smooth;
    r_eff    = r_unit + r_sw;

    I(VOUT, VSS) <+ (V(VOUT, VSS) - v_th_oc) / r_eff + c_out * ddt(V(VOUT, VSS));
end

endmodule
