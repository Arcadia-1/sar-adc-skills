// Process-independent DAC Sampling-Clock Rising-Edge Jitter Injector
//
// Passes CLK_IN to CLK_OUT with calibrated zero-mean Gaussian RMS timing jitter
// (`t_jitter_rms`) injected on each rising sampling edge. Uses a strictly causal
// constant pedestal delay (`t_ped = 6 * t_jitter_rms`) so negative Gaussian
// timing draws remain causal without altering coherent signal phase.
// When `t_jitter_rms == 0.0`, passes CLK_IN through with zero delay.

`include "constants.vams"
`include "disciplines.vams"

module va_dac_clk_jitter(
    input  electrical CLK_IN,
    input  electrical VSS,
    output electrical CLK_OUT
);

parameter real    vdd          = 1.0   from (0:inf);
parameter real    t_jitter_rms = 0.0   from [0:inf); // RMS rising-edge jitter [s]
parameter integer seed         = 19;                 // Gaussian PRNG seed
parameter real    tr           = 20p   from (0:inf);
parameter real    tf           = 20p   from (0:inf);

integer clk_state, armed_rise, armed_fall, rng_seed;
real t_rise_fire, t_fall_fire, t_ped, dt_jit, dly, v_jit;

analog begin
    @(initial_step) begin
        clk_state   = (V(CLK_IN, VSS) > 0.5 * vdd) ? 1 : 0;
        armed_rise  = 0;
        armed_fall  = 0;
        t_rise_fire = -1.0;
        t_fall_fire = -1.0;
        rng_seed    = seed;
        t_ped       = (t_jitter_rms > 0.0) ? (6.0 * t_jitter_rms) : 0.0;
    end

    @(cross(V(CLK_IN, VSS) - 0.5 * vdd, +1)) begin
        if (t_jitter_rms > 0.0) begin
            t_ped  = 6.0 * t_jitter_rms;
            dt_jit = $rdist_normal(rng_seed, 0.0, t_jitter_rms);
            if (dt_jit >  5.0 * t_jitter_rms) dt_jit =  5.0 * t_jitter_rms;
            if (dt_jit < -5.0 * t_jitter_rms) dt_jit = -5.0 * t_jitter_rms;
            dly = t_ped + dt_jit;
            if (dly < 1e-15) dly = 1e-15;
            armed_rise  = 1;
            t_rise_fire = $abstime + dly;
        end else begin
            clk_state = 1;
        end
    end

    @(cross(V(CLK_IN, VSS) - 0.5 * vdd, -1)) begin
        if (t_jitter_rms > 0.0) begin
            t_ped       = 6.0 * t_jitter_rms;
            armed_fall  = 1;
            t_fall_fire = $abstime + t_ped;
        end else begin
            clk_state = 0;
        end
    end

    @(timer(t_rise_fire)) begin
        if (armed_rise) begin
            clk_state  = 1;
            armed_rise = 0;
        end
    end

    @(timer(t_fall_fire)) begin
        if (armed_fall) begin
            clk_state  = 0;
            armed_fall = 0;
        end
    end

    v_jit = transition(clk_state * vdd, 0.0, tr, tf);
    V(CLK_OUT, VSS) <+ (t_jitter_rms > 0.0) ? v_jit : V(CLK_IN, VSS);
end

endmodule
