// =============================================================================
// Process-Independent Current-Steering DAC TB — Static DNL / INL Sweep (10-bit)
// =============================================================================
// Steps all 1024 digital input codes (0..1023) using `va_dac_ramp_gen_10b.va`
// and strobes the settled differential output V(IOUTP) - V(IOUTN) across matched
// load resistors `rload` using `strobeoutput=strobeonly`.
//
// DUT interface contract (10-bit differential Current-Steering DAC):
//   subckt dut_cs_dac DIN9 DIN8 DIN7 DIN6 DIN5 DIN4 DIN3 DIN2 DIN1 DIN0 VDD VSS IOUTP IOUTN
// =============================================================================

simulator lang=spectre
global 0

include "models_corner.scs"
include "dut_subckt.scs"
ahdl_include "../../va/va_dac_ramp_gen_10b.va"

parameters \
    vdd=1.2 \
    vdd_dig=1.0 \
    rload=50 \
    cload=100f \
    ts=10n \
    n_codes=1024 \
    tr=20p \
    tf=20p \
    temp_c=27

VSUP (VDD 0) vsource dc=vdd type=dc
VGND (VSS 0) vsource dc=0   type=dc

// Clock edges at t = ts, 2*ts, ..., (n_codes-1)*ts so code 0 holds on [0, ts)
VCLK (CLK 0) vsource type=pulse val0=0 val1=vdd_dig \
    period=ts delay=ts rise=tr fall=tf width=0.5*ts

I_GEN (CLK VSS \
    DIN9 DIN8 DIN7 DIN6 DIN5 DIN4 DIN3 DIN2 DIN1 DIN0 \
    CODE_MON) va_dac_ramp_gen_10b \
    vdd=vdd_dig vth=0.5*vdd_dig start_code=0 stop_code=(n_codes-1) step_size=1 tr=tr

I0 (DIN9 DIN8 DIN7 DIN6 DIN5 DIN4 DIN3 DIN2 DIN1 DIN0 \
    VDD VSS IOUTP IOUTN) dut_cs_dac

RLP (IOUTP VSS) resistor  r=rload
RLN (IOUTN VSS) resistor  r=rload
CLP (IOUTP VSS) capacitor c=cload
CLN (IOUTN VSS) capacitor c=cload

simulatorOptions options psfversion="1.4.0" \
    reltol=1e-5 vabstol=1e-8 iabstol=1e-13 \
    temp=temp_c tnom=27 gmin=1e-12 rforce=1 maxnotes=5 maxwarns=5

// Strobe at 0.85*ts within each code slot (strobedelay < strobeperiod!)
tran tran stop=n_codes*ts errpreset=moderate \
    strobeperiod=ts strobedelay=0.85*ts strobeoutput=strobeonly

save IOUTP IOUTN CODE_MON
saveOptions options save=selected
