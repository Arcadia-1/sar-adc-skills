// =============================================================================
// Process-Independent SerDes CDR TB — Frequency Offset (ppm) & 2*pi PI Wrap
// =============================================================================
// Runs a closed-loop 10 Gb/s Type-II 2nd-order Bang-Bang PI CDR tracking a
// genuine TX-vs-RX clock frequency offset (`ppm_offset`, default +1000 ppm)
// over `t_stop = 350 ns` (3500 UI -> 3.5 full `2*pi` / `64`-code PI wraps):
//
//   Independent TX Clock (bit_rate * (1 + ppm_offset*1e-6)) -> PRBS-7
//     -> [dut_bbpd -> dut_cdr_loop -> dut_pi (10 GHz local ref)]
//
// Extracts:
//   - Converged frequency accumulator `FREQ_MON` -> recovered `ppm` & `ppm_err_pct`
//   - Number of full `0..n_codes` (`2*pi`) PI wraparounds (`n_wraps >= 2`)
//   - Peak phase glitch across `2*pi` wrap boundaries (`max_wrap_glitch_mui`)
//   - Latency-aligned post-lock bit errors (`bit_errors == 0`)
//
// Increase `ppm_offset` beyond the loop acquisition/clamp limit (e.g. `40000`
// ppm) or set `ki = 0` (Type-I fault) to verify lock-loss / cycle-slip detection.
//
// DUT interface contracts:
//   subckt dut_bbpd     INP INN CLKP CLKN VDD VSS UP DN DOUT
//   subckt dut_cdr_loop UP DN CLK VDD VSS VCODE FREQ_MON
//   subckt dut_pi       CKI_P CKI_N CKQ_P CKQ_N VCODE VDD VSS CLKP CLKN
// =============================================================================

simulator lang=spectre
global 0

include "models_corner.scs"
include "dut_subckt.scs"
ahdl_include "../../va/va_prbs_gen.va"

parameters \
    vdd=1.0 \
    vcm_clk=0.5 \
    bit_rate=10G \
    ppm_offset=1000 \
    n_codes=64 \
    t_stop=350n \
    temp_c=27

parameters \
    f_tx=bit_rate*(1 + ppm_offset*1e-6) \
    t_ui_tx=1/f_tx

VSUP (VDD 0) vsource dc=vdd type=dc
VGND (VSS 0) vsource dc=0   type=dc

// Local RX 10 GHz quadrature reference clocks (zero ppm offset)
VCKIP (CKI_P VSS) vsource dc=vcm_clk type=sine freq=bit_rate ampl= 0.5 sinephase=0
VCKIN (CKI_N VSS) vsource dc=vcm_clk type=sine freq=bit_rate ampl=-0.5 sinephase=0
VCKQP (CKQ_P VSS) vsource dc=vcm_clk type=sine freq=bit_rate ampl= 0.5 sinephase=-90
VCKQN (CKQ_N VSS) vsource dc=vcm_clk type=sine freq=bit_rate ampl=-0.5 sinephase=-90

// Independent TX clock with genuine frequency offset `ppm_offset`
VTXCLK (TX_CLKP VSS) vsource type=pulse val0=0 val1=vdd \
    period=t_ui_tx delay=0 rise=5p fall=5p width=(0.5*t_ui_tx - 5p)

// Frequency-offset PRBS-7 NRZ data stream into matched 100-ohm termination
I_PRBS (TX_CLKP VSS DATA_P DATA_N TX_BIT) va_prbs_gen \
    mode=0 v_swing=0.8 v_cm=0.5 t_rf=15p r_src=50
RL_P   (DATA_P VSS) resistor r=50
RL_N   (DATA_N VSS) resistor r=50

// Closed-loop 2nd-order Bang-Bang PI CDR
I_BBPD (DATA_P DATA_N RX_CLKP RX_CLKN VDD VSS UP DN RX_DOUT) dut_bbpd
I_LF   (UP DN RX_CLKP VDD VSS RX_VCODE FREQ_MON) dut_cdr_loop
I_PI   (CKI_P CKI_N CKQ_P CKQ_N RX_VCODE VDD VSS RX_CLKP RX_CLKN) dut_pi

simulatorOptions options psfversion="1.4.0" \
    reltol=1e-4 vabstol=1e-7 iabstol=1e-12 \
    temp=temp_c tnom=27 gmin=1e-12 rforce=1 maxnotes=5 maxwarns=5

tran tran stop=t_stop errpreset=moderate maxstep=5p

save TX_BIT RX_DOUT TX_CLKP RX_CLKP CKI_P CKI_N RX_VCODE FREQ_MON
saveOptions options save=selected
