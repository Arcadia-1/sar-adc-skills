// =============================================================================
// Process-Independent SerDes PAM4 TB — Lossy Channel + 1-Tap PAM4 DFE & 0-BER
// =============================================================================
// Drives a 10 Gbaud (20 Gb/s) Gray-coded PRBS-7 PAM4 stream through a passive
// causal lossy `mtline` channel (`channel_diff_lossy.scs`, `ch_len = 0.35 m`,
// ~ -10 dB @ 5 GHz — severe enough to close all 3 PAM4 eyes before DFE!) into
// a 3-threshold PAM4 slicer + 1-tap PAM4 DFE (`dut_pam4_dfe`).
//
// Extracts:
//   - Before-DFE PAM4 3-eye heights/widths (closed by post-cursor ISI)
//   - After-DFE PAM4 3-eye heights/widths (all 3 eyes open!) & RLM
//   - Latency-aligned symbol errors (`SER`) and Gray-decoded bit errors (`BER`)
//
// DUT interface contracts:
//   subckt dut_pam4_tx  INP INN CLK VDD VSS OUTP OUTN
//   subckt dut_pam4_dfe INP INN CLK H1 VREF VDD VSS SUMP SUMN SYM_OUT MSB_OUT LSB_OUT
// =============================================================================

simulator lang=spectre
global 0

include "models_corner.scs"
include "dut_subckt.scs"
include "../channel/channel_diff_lossy.scs"
ahdl_include "../../va/va_pam4_gen.va"

parameters \
    vdd=1.0 \
    baud_rate=10G \
    ch_len=0.35 \
    z0=50 \
    v_ref_dfe=0.305 \
    h1_dfe=0.092 \
    t_clk_rx_off=55p \
    n_sym=240 \
    temp_c=27

parameters \
    ui=1/baud_rate \
    t_stop=n_sym*ui

VSUP (VDD 0) vsource dc=vdd type=dc
VGND (VSS 0) vsource dc=0   type=dc
VH1  (H1   VSS) vsource dc=h1_dfe    type=dc
VRF  (VREF VSS) vsource dc=v_ref_dfe type=dc

VCLK_GEN (CLK_GEN 0) vsource type=pulse val0=0 val1=vdd period=ui delay=0            rise=5p fall=5p width=0.5*ui
VCLK_TX  (CLK_TX  0) vsource type=pulse val0=0 val1=vdd period=ui delay=0.5*ui       rise=5p fall=5p width=0.5*ui
VCLK_RX  (CLK_RX  0) vsource type=pulse val0=0 val1=vdd period=ui delay=t_clk_rx_off rise=5p fall=5p width=0.5*ui

// 1. Gray-coded PRBS-7 PAM4 source -> 3-tap PAM4 TX
I_GEN (CLK_GEN VSS DINP DINN SYM_TX) va_pam4_gen \
    mode=0 vth=0.5*vdd v_swing=0.90 v_cm=0.50 rlm_err=0.0 t_rf=10p r_src=1
I_TX  (DINP DINN CLK_TX VDD VSS TXP TXN) dut_pam4_tx

// 2. Causal passive lossy differential channel + 100-ohm RX termination
I_CH  (TXP TXN RXP RXN VSS) channel_diff_lossy ch_len=ch_len
RLP   (RXP VSS) resistor r=z0
RLN   (RXN VSS) resistor r=z0

// 3. 3-threshold PAM4 slicer + 1-tap PAM4 DFE + Gray decoder
I_DFE (RXP RXN CLK_RX H1 VREF VDD VSS SUMP SUMN SYM_RX MSB_RX LSB_RX) dut_pam4_dfe

simulatorOptions options psfversion="1.4.0" \
    reltol=1e-4 vabstol=1e-7 iabstol=1e-12 \
    temp=temp_c tnom=27 gmin=1e-12 rforce=1 maxnotes=5 maxwarns=5

tran tran stop=t_stop errpreset=conservative maxstep=4p

save SYM_TX RXP RXN SUMP SUMN SYM_RX MSB_RX LSB_RX CLK_RX
saveOptions options save=selected
