// =============================================================================
// Process-Independent End-to-End SerDes Link Top-Level Testbench (10 Gb/s NRZ)
// =============================================================================
// Verifies the complete high-speed transceiver equalization chain across a
// severe long-reach backplane channel (`ch_len = 0.85 m`, ~ -24 dB @ 5 GHz!):
//   PRBS-7 -> 4-Tap TX FFE -> Causal Lossy MTLINE Channel
//          -> RX CTLE + VGA -> 3-Tap DFE + Slicer
//
// Extracts stage-by-stage eye diagrams (TX -> after Channel -> after CTLE ->
// after DFE) and verifies bit-error-free recovery against the TX PRBS stream.
//
// DUT interface contracts (plug in any mix of behavioral / transistor blocks!):
//   subckt dut_link_tx   INP INN CLK VDD VSS OUTP OUTN
//   subckt dut_link_ctle INP INN VBOOST VOFF_CAL VDD VSS OUTP OUTN
//   subckt dut_link_dfe  INP INN CLK H1 H2 H3 VREF_ERR VDD VSS SUMP SUMN DOUTP DOUTN ERRP ERRN
// =============================================================================

simulator lang=spectre
global 0

include "models_corner.scs"
include "dut_subckt.scs"
include "../channel/channel_diff_lossy.scs"
ahdl_include "../../va/va_prbs_gen.va"

parameters \
    vdd=1.0 \
    bit_rate=10G \
    ch_len=0.85 \
    vboost=0.0 \
    h1_dfe=0.055 \
    h2_dfe=0.015 \
    h3_dfe=0.005 \
    vref_err=0.25 \
    t_clk_rx_off=10p \
    n_ui=220 \
    temp_c=27

parameters \
    ui=1/bit_rate \
    t_stop=n_ui*ui

VSUP (VDD 0) vsource dc=vdd type=dc
VGND (VSS 0) vsource dc=0   type=dc
VBST (VBOOST   VSS) vsource dc=vboost   type=dc
VOFF (VOFF_CAL VSS) vsource dc=0        type=dc
VH1  (H1 VSS)       vsource dc=h1_dfe   type=dc
VH2  (H2 VSS)       vsource dc=h2_dfe   type=dc
VH3  (H3 VSS)       vsource dc=h3_dfe   type=dc
VREF (VREF_ERR VSS) vsource dc=vref_err type=dc

VCLK_TX (CLK_TX 0) vsource type=pulse val0=0 val1=vdd period=ui delay=0            rise=5p fall=5p width=0.5*ui
VCLK_RX (CLK_RX 0) vsource type=pulse val0=0 val1=vdd period=ui delay=t_clk_rx_off rise=5p fall=5p width=0.5*ui

// 1. PRBS-7 Source
I_PRBS (CLK_TX VSS DINP DINN BIT_TX) va_prbs_gen mode=0 v_swing=0.8 v_cm=0.5 t_rf=10p r_src=1

// 2. 4-Tap TX FFE
I_TX   (DINP DINN CLK_TX VDD VSS TXP TXN) dut_link_tx

// 3. Long-Reach Causal Differential Channel (~ -24 dB @ 5 GHz!)
I_CH   (TXP TXN RXP RXN VSS) channel_diff_lossy ch_len=ch_len

// 4. RX CTLE + VGA Front End (includes matched 50-ohm input termination)
I_CTLE (RXP RXN VBOOST VOFF_CAL VDD VSS EQP EQN) dut_link_ctle

// 5. RX 3-Tap DFE + Slicer
I_DFE  (EQP EQN CLK_RX H1 H2 H3 VREF_ERR VDD VSS SUMP SUMN DOUTP DOUTN ERRP ERRN) dut_link_dfe

simulatorOptions options psfversion="1.4.0" \
    reltol=1e-4 vabstol=1e-7 iabstol=1e-12 \
    temp=temp_c tnom=27 gmin=1e-12 rforce=1 maxnotes=5 maxwarns=5

tran tran stop=t_stop errpreset=conservative maxstep=5p

save BIT_TX TXP TXN RXP RXN EQP EQN SUMP SUMN DOUTP DOUTN
saveOptions options save=selected
