// =============================================================================
// Process-Independent SerDes TX + FFE TB — Channel Equalization (SBR & Eye)
// =============================================================================
// Drives the TX/FFE DUT with a PRBS-7 stream (`10 Gb/s`, `UI = 100 ps`) through
// the passive causal 100-ohm lossy differential channel (`channel_diff_lossy.scs`)
// into matched 50-ohm RX termination, plus a parallel isolated-pulse SBR replica.
//
// DUT interface contract:
//   subckt dut_tx INP INN CLK VDD VSS OUTP OUTN
// =============================================================================

simulator lang=spectre
global 0

include "models_corner.scs"
include "dut_subckt.scs"
include "../channel/channel_diff_lossy.scs"
ahdl_include "../../va/va_prbs_gen.va"

parameters \
    vdd=1.0 \
    bit_rate=10G \
    z0=50 \
    ch_len=0.50 \
    n_ui=180 \
    temp_c=27

parameters \
    ui=1/bit_rate \
    t_stop=n_ui*ui

VSUP (VDD 0) vsource dc=vdd type=dc
VGND (VSS 0) vsource dc=0   type=dc
VCLK (CLK 0) vsource type=pulse val0=0 val1=vdd period=ui delay=0 rise=5p fall=5p width=0.5*ui

// --- Replica A: PRBS-7 Eye through TX + Channel ---
I_PRBS (CLK VSS DINP DINN BIT_MON) va_prbs_gen mode=0 v_swing=0.8 v_cm=0.5 t_rf=10p r_src=1
I_TX   (DINP DINN CLK VDD VSS TXP TXN) dut_tx
I_CH   (TXP TXN RXP RXN VSS) channel_diff_lossy ch_len=ch_len
RRXP   (RXP VSS) resistor r=z0
RRXN   (RXN VSS) resistor r=z0

// --- Replica B: Isolated 1-UI Pulse SBR through TX + Channel ---
I_SBR_G (CLK VSS SDINP SDINN SBIT) va_prbs_gen mode=2 pulse_idx=15 v_swing=0.8 v_cm=0.5 t_rf=10p r_src=1
I_TX_S  (SDINP SDINN CLK VDD VSS STXP STXN) dut_tx
I_CH_S  (STXP STXN SRXP SRXN VSS) channel_diff_lossy ch_len=ch_len
SRRXP   (SRXP VSS) resistor r=z0
SRRXN   (SRXN VSS) resistor r=z0

simulatorOptions options psfversion="1.4.0" \
    reltol=1e-4 vabstol=1e-7 iabstol=1e-12 \
    temp=temp_c tnom=27 gmin=1e-12 rforce=1 maxnotes=5 maxwarns=5

tran tran stop=t_stop errpreset=conservative maxstep=5p

save TXP TXN RXP RXN SRXP SRXN
saveOptions options save=selected
