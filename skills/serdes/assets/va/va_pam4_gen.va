// Process-independent Gray-Coded 4-Level PAM4 PRBS-7 / PRBS-9 Generator
//
// Generates differential 4-level PAM4 symbols clocked on rising edges of CLK:
//   - Gray code mapping `(MSB, LSB)` -> symbol index `0..3` -> nominal levels:
//       (0, 0) -> idx 0 -> -1.0
//       (0, 1) -> idx 1 -> -1/3 * (1 - rlm_err)
//       (1, 1) -> idx 2 -> +1/3 * (1 - rlm_err)
//       (1, 0) -> idx 3 -> +1.0
//   - `mode = 0`: PRBS-7 (x^7 + x^6 + 1) MSB + decorrelated tap LSB
//   - `mode = 1`: PRBS-9 (x^9 + x^5 + 1) MSB + decorrelated tap LSB
//   - `mode = 2`: Deterministic repeating 4-level staircase (0, 1, 2, 3, 2, 1)
//
// Configurable `rlm_err` shifts the inner levels so IEEE 802.3 RLM = 1 - |rlm_err|.
// `SYM_MON` outputs the exact ground-truth symbol index `0, 1, 2, 3` [V] for
// Gray-decoded symbol-error and bit-error verification.

`include "constants.vams"
`include "disciplines.vams"

module va_pam4_gen(
    input  electrical CLK,
    input  electrical VSS,
    output electrical OUTP,
    output electrical OUTN,
    output electrical SYM_MON
);

parameter integer mode    = 0      from [0:2];     // 0=PRBS7, 1=PRBS9, 2=4-level ramp
parameter real    vth     = 0.50   from (0:inf);   // CLK threshold [V]
parameter real    v_swing = 0.90   from (0.01:5.0);// outer peak-to-peak differential swing [Vpp_diff]
parameter real    v_cm    = 0.50;                  // output common-mode voltage [V]
parameter real    rlm_err = 0.0    from (-0.4:0.4);// inner-level mismatch (RLM = 1 - |rlm_err|)
parameter real    t_rf    = 15e-12 from (1e-12:inf);// transition edge time [s]
parameter real    r_src   = 50.0   from (0.01:1e6);// single-ended source resistance [ohm]

integer sr_a[8:0], sr_b[8:0];
integer fb_a, fb_b, msb, lsb, sym_idx, ramp_cnt, k;
real lvl_norm, inner_mag, vp_tgt, vn_tgt, vp_sm, vn_sm;

analog begin
    @(initial_step) begin
        for (k = 0; k <= 8; k = k + 1) begin
            sr_a[k] = 1;
            sr_b[k] = (k % 2 == 0) ? 1 : 0;
        end
        sr_b[0]  = 1;
        ramp_cnt = 0;
        sym_idx  = 0;
        lvl_norm = -1.0;
    end

    @(cross(V(CLK, VSS) - vth, +1)) begin
        if (mode == 0) begin
            // Two differently seeded PRBS-7 LFSRs (x^7 + x^6 + 1) for MSB and LSB
            fb_a = sr_a[6] ^ sr_a[5];
            fb_b = sr_b[6] ^ sr_b[5];
            for (k = 6; k >= 1; k = k - 1) begin
                sr_a[k] = sr_a[k - 1];
                sr_b[k] = sr_b[k - 1];
            end
            sr_a[0] = fb_a;
            sr_b[0] = fb_b;
            msb = sr_a[6];
            lsb = sr_b[3];
        end else if (mode == 1) begin
            // Two differently seeded PRBS-9 LFSRs (x^9 + x^5 + 1)
            fb_a = sr_a[8] ^ sr_a[4];
            fb_b = sr_b[8] ^ sr_b[4];
            for (k = 8; k >= 1; k = k - 1) begin
                sr_a[k] = sr_a[k - 1];
                sr_b[k] = sr_b[k - 1];
            end
            sr_a[0] = fb_a;
            sr_b[0] = fb_b;
            msb = sr_a[8];
            lsb = sr_b[4];
        end else begin
            ramp_cnt = (ramp_cnt + 1) % 4;
            msb = (ramp_cnt >= 2) ? 1 : 0;
            lsb = (ramp_cnt == 1 || ramp_cnt == 2) ? 1 : 0;
        end

        // Gray code (MSB, LSB) -> symbol level index 0..3
        if (msb == 0 && lsb == 0)
            sym_idx = 0;
        else if (msb == 0 && lsb == 1)
            sym_idx = 1;
        else if (msb == 1 && lsb == 1)
            sym_idx = 2;
        else
            sym_idx = 3;

        inner_mag = (1.0 / 3.0) * (1.0 - rlm_err);
        if (sym_idx == 0)
            lvl_norm = -1.0;
        else if (sym_idx == 1)
            lvl_norm = -inner_mag;
        else if (sym_idx == 2)
            lvl_norm =  inner_mag;
        else
            lvl_norm =  1.0;
    end

    vp_tgt = v_cm + 0.25 * v_swing * lvl_norm;
    vn_tgt = v_cm - 0.25 * v_swing * lvl_norm;
    vp_sm  = transition(vp_tgt, 0.0, t_rf, t_rf);
    vn_sm  = transition(vn_tgt, 0.0, t_rf, t_rf);

    I(OUTP, VSS)    <+ (V(OUTP, VSS) - vp_sm) / r_src;
    I(OUTN, VSS)    <+ (V(OUTN, VSS) - vn_sm) / r_src;
    V(SYM_MON, VSS) <+ transition(1.0 * sym_idx, 0.0, t_rf, t_rf);
end

endmodule
