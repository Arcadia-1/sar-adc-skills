// =============================================================================
// Process-Independent Bandgap Reference TB — Power-Up Startup & Dead-State Check
// =============================================================================
// Ramps VDD from 0 V to vdd_nom with explicit zero initial condition on VREF
// to verify startup immunity to the zero-current dead state, startup time to
// within 1% of final VREF, and overshoot.
//
// DUT interface contract:
//   subckt dut_bandgap VDD VREF VSS
// =============================================================================

simulator lang=spectre
global 0

include "models_corner.scs"
include "dut_subckt.scs"

parameters \
    vdd_nom=1.0 \
    t_delay=2u \
    t_ramp=10u \
    t_stop=40u \
    cload=1p \
    temp_c=27

VSUP (VDD 0) vsource type=pwl wave=[ \
    0               0 \
    t_delay         0 \
    (t_delay+t_ramp) vdd_nom \
    t_stop          vdd_nom ]
VGND (VSS 0) vsource dc=0 type=dc

I0 (VDD VREF VSS) dut_bandgap
CL (VREF VSS) capacitor c=cload

ic VREF=0

simulatorOptions options psfversion="1.4.0" \
    reltol=1e-4 vabstol=1e-7 iabstol=1e-13 \
    temp=temp_c tnom=27 gmin=1e-12 rforce=1 maxnotes=5 maxwarns=5

tran tran stop=t_stop errpreset=conservative

save VDD VREF VSUP:p
saveOptions options save=selected
