// =============================================================================
// Process-Independent Pierce Crystal Oscillator TB — Small-Signal Negative Resistance
// =============================================================================
// Replaces the quartz crystal motional arm (Lm-Cm-Rm) between XI and XO_P with
// a 1 A AC test current source while retaining the crystal package shunt cap C0,
// load capacitors CL1/CL2, and optional drive-limiting series resistor Rs.
//
// Measures across 1 MHz - 100 MHz:
//   - Small-signal port impedance Z_in(f) = (V(XI) - V(XO_P)) / I_test
//   - Negative resistance R_neg(f0) = -Re{Z_in(f0)} [Ohm]
//   - Startup allowance / oscillation margin |R_neg(f0)| / R_m (target >= 5x)
//   - Effective load + shunt capacitance C_eff(f0) = -1 / (2*pi*f0*Im{Z_in(f0)})
//   - Active negative-resistance bandwidth [f_min, f_max] where Re{Z_in(f)} < 0
//
// DUT interface contract (4-pin Pierce sustaining amplifier w/ DC feedback):
//   subckt dut_xo_amp XI XO VDD VSS
// =============================================================================

simulator lang=spectre
global 0

include "models_corner.scs"
include "dut_subckt.scs"

parameters \
    vdd=1.8 \
    c_l1=16p \
    c_l2=16p \
    c0_xtal=2.0p \
    r_series=1 \
    temp_c=27

VSUP (VDD 0) vsource dc=vdd type=dc
VGND (VSS 0) vsource dc=0   type=dc

// Pierce sustaining amplifier DUT (includes internal self-bias R_fb)
I0 (XI XO VDD VSS) dut_xo_amp

// Optional drive-limiting series resistor between XO output and crystal pin XO_P
RS  (XO XO_P) resistor r=r_series

// On-chip / PCB load capacitors and quartz package shunt capacitance C0
CL1 (XI   VSS) capacitor c=c_l1
CL2 (XO_P VSS) capacitor c=c_l2
C0  (XI   XO_P) capacitor c=c0_xtal

// 1 A AC test current injected into XI and extracted from XO_P (zero DC bias impact)
// In Spectre, positive isource(p n) flows internally p -> n, so (XO_P XI) injects +1 A into XI.
ITEST (XO_P XI) isource dc=0 mag=1 type=dc

simulatorOptions options psfversion="1.4.0" \
    reltol=1e-5 vabstol=1e-8 iabstol=1e-13 \
    temp=temp_c tnom=27 gmin=1e-12 rforce=1 maxnotes=5 maxwarns=5

dcOp dc
ac_negr ac start=1M stop=100M dec=100

save XI XO XO_P VSUP:p
saveOptions options save=selected
