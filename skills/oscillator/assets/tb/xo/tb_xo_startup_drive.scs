// =============================================================================
// Process-Independent Pierce Crystal Oscillator TB — Transient Startup & Drive Level
// =============================================================================
// Simulates closed-loop Pierce XO startup and steady-state amplitude with a full
// Butterworth-Van Dyke (BVD) 24 MHz quartz crystal model (Lm, Cm, Rm, C0).
//
// Uses Q-scaling (L_sim = l_m / q_scale, C_sim = c_m * q_scale) + a brief AC
// current kick pulse (zero DC perturbation; avoids DC capacitor-charging blowup
// from setting `ic` on series LM!) with trapezoidal integration (`method=traponly`,
// run with `+aps` so numerical Gear-2 damping never kills high-Q oscillation).
// Preserves exact Rm, steady-state motional current Im_pk, crystal drive power
// P_xtal (< 100 uW), swings (V_XI,pp, V_XO,pp), duty cycle, and supply current.
// Set `q_scale=1` and extend `t_stop` for unscaled full-Q startup signoff.
//
// DUT interface contract (4-pin Pierce sustaining amplifier w/ DC feedback):
//   subckt dut_xo_amp XI XO VDD VSS
// =============================================================================

simulator lang=spectre
global 0

include "models_corner.scs"
include "dut_subckt.scs"

parameters \
    vdd=1.8 \
    l_m=7.329368m \
    c_m=6.0f \
    r_m=40 \
    c0_xtal=2.0p \
    c_l1=16p \
    c_l2=16p \
    r_series=1 \
    q_scale=20 \
    i_kick=200u \
    t_stop=45u \
    t_maxstep=1.0n \
    temp_c=27

VSUP (VDD 0) vsource dc=vdd type=dc
VGND (VSS 0) vsource dc=0   type=dc

// Pierce sustaining amplifier DUT
I0 (XI XO VDD VSS) dut_xo_amp

// Optional drive-limiting series resistor and load capacitors
RS  (XO   XO_P) resistor  r=r_series
CL1 (XI   VSS)  capacitor c=c_l1
CL2 (XO_P VSS)  capacitor c=c_l2

// Butterworth-Van Dyke (BVD) quartz resonator with 0 V motional current probe
C0   (XI   XO_P) capacitor c=c0_xtal
V_IM (XI   M1)   vsource   dc=0 type=dc
RM   (M1   M2)   resistor  r=r_m
LM   (M2   M3)   inductor  l=l_m/q_scale
CM   (M3   XO_P) capacitor c=c_m*q_scale

// Brief startup kick strictly inside t < 35 ns (zero DC perturbation)
IKICK (XO_P XI) isource type=pulse val0=0 val1=i_kick delay=10n rise=1n fall=1n width=20n

simulatorOptions options psfversion="1.4.0" \
    reltol=1e-4 vabstol=1e-7 iabstol=1e-13 \
    temp=temp_c tnom=27 gmin=1e-12 rforce=1 maxnotes=5 maxwarns=5

// Trapezoidal integration (zero artificial damping on high-Q quartz resonators)
tran_start tran stop=t_stop method=traponly maxstep=t_maxstep

save XI XO XO_P V_IM:p VSUP:p
saveOptions options save=selected
