// Process-independent Output-Capacitorless (Capless) LDO macro-model
//
// Tuned for on-chip SoC domains (C_L = 10..50 pF, wide UGF ~ 80-150 MHz, fast
// transient load-step recovery) with breakable FB_IN for Spectre `stb`.

`include "constants.vams"
`include "disciplines.vams"

module va_ldo_capless(
    input  electrical VDD,
    input  electrical VREF,
    output electrical VOUT,
    input  electrical FB_IN,
    input  electrical VSS
);

parameter real a_ea      = 150.0  from (1:inf);
parameter real ro_ea     = 50e3   from (0:inf);
parameter real c_ea      = 100f   from (0:inf);
parameter real c_m       = 1.2p   from [0:inf);
parameter real r_z       = 250.0  from [0:inf);
parameter real gm_pass   = 40e-3  from (0:inf);
parameter real ro_pass   = 400.0  from (0:inf);
parameter real r_on_min  = 10.0   from (0:inf);
parameter real vsg0      = 0.45   from (0:inf);
parameter real i_q       = 120e-6 from [0:inf);
parameter real vn_ea_th  = 15e-9  from [0:inf);

electrical vg, vm_mid;
real gm_ea, v_err, vsg_eff, vds_p, i_sat, i_max_triode, i_pass;

analog begin
    gm_ea = a_ea / ro_ea;
    v_err = V(VREF, VSS) - V(FB_IN, VSS);

    I(vg, VSS) <+ gm_ea * v_err
                  + c_ea * ddt(V(vg, VSS))
                  + white_noise((gm_ea * vn_ea_th) * (gm_ea * vn_ea_th), "capless_ea_th");
    I(vg, VDD) <+ (V(vg, VDD) + vsg0) / ro_ea;
    I(vg, VSS) <+ -1e-2 * max(V(VSS) - V(vg), 0.0);

    if (c_m > 0.0) begin
        if (r_z > 0.0) begin
            I(vg, vm_mid)   <+ V(vg, vm_mid) / r_z;
            I(vm_mid, VOUT) <+ c_m * ddt(V(vm_mid, VOUT));
        end else begin
            V(vm_mid, vg)   <+ 0.0;
            I(vg, VOUT)     <+ c_m * ddt(V(vg, VOUT));
        end
    end else begin
        V(vm_mid, VSS) <+ 0.0;
    end

    vsg_eff      = V(VDD, vg) - vsg0;
    vds_p        = max(V(VDD, VOUT), 0.0);
    i_sat        = gm_pass * vsg_eff + V(VDD, VOUT) / ro_pass;
    i_max_triode = vds_p / r_on_min;
    i_pass       = (i_max_triode > 1e-9) ? (i_max_triode * tanh(max(i_sat, 0.0) / i_max_triode)) : 0.0;

    I(VDD, VOUT) <+ i_pass;
    I(VDD, VSS)  <+ i_q * tanh(max(V(VDD, VSS), 0.0) / 0.2);
end

endmodule
