`include "constants.vams"
`include "disciplines.vams"

`default_transition 30p

module L2_comparator_ideal(
    input  electrical CMPCK,
    input  electrical VINN,
    input  electrical VINP,
    output electrical DCMPN,
    output electrical DCMPP
);

parameter real vdd = 1, td_cmp = 100.0p; // comparator delay
integer xoutp, xoutn;

analog begin
    @(initial_step) begin
        xoutp = 0;
        xoutn = 0;
    end

    // Evaluate when CMPCK rises (break exact VINP == VINN tie cleanly to avoid async deadlock)
    @(cross(V(CMPCK) - vdd/2, +1)) begin
        if (V(VINP) >= V(VINN)) begin
            xoutp = 1;
            xoutn = 0;
        end else begin
            xoutp = 0;
            xoutn = 1;
        end
    end

    // Reset outputs when CMPCK falls
    @(cross(V(CMPCK) - vdd/2, -1)) begin
        xoutp = 0;
        xoutn = 0;
    end

    V(DCMPP) <+ transition(xoutp * vdd, td_cmp);
    V(DCMPN) <+ transition(xoutn * vdd, td_cmp);
end

endmodule
