// Process-independent behavioral PMOS-pass LDO regulator macro-model
//
// Exposes an explicit feedback sense pin (FB_IN) so Spectre `stb` analysis can
// insert an `iprobe` directly in the unity-gain feedback path without editing
// the model:
//   - Closed-loop use : connect FB_IN to VOUT
//   - Stability (`stb`): connect `IPRB (VOUT FB_IN) iprobe`
//
// Models:
//   - Error amplifier DC gain (a_ea) and dominant pole (ro_ea, c_ea)
//   - Miller compensation capacitor (c_m) + nulling resistor (r_z)
//   - PMOS pass stage transconductance (gm_pass) + output resistance (ro_pass)
//     creating realistic DC loop gain, PSRR(f), and load-step droop
//   - Reference/EA input-referred white noise density (vn_ea_rt_hz) for Spectre `noise`

`include "constants.vams"
`include "disciplines.vams"

module va_ldo_ideal(
    input  electrical VDD,
    input  electrical VREF,
    output electrical VOUT,
    input  electrical FB_IN,
    input  electrical VSS
);

parameter real a_ea        = 100.0   from (1:inf);    // EA DC voltage gain [V/V] (40 dB)
parameter real ro_ea       = 100e3   from (0:inf);    // EA output impedance [ohm]
parameter real c_ea        = 200f    from (0:inf);    // EA output parasitic cap [F]
parameter real c_m         = 2p      from [0:inf);    // Miller compensation cap [F]
parameter real r_z         = 500.0   from [0:inf);    // nulling resistor [ohm]
parameter real gm_pass     = 20e-3   from (0:inf);    // PMOS pass transconductance [S]
parameter real ro_pass     = 500.0   from (0:inf);    // PMOS pass rds [ohm]
parameter real vsg0        = 0.5     from (0:inf);    // nominal PMOS Vsg bias [V]
parameter real vn_ea_rt_hz = 20e-9   from [0:inf);    // EA input-referred noise [V/sqrt(Hz)]

electrical vg, vm_mid;
real gm_ea, v_err, vsg_drive;

analog begin
    gm_ea = a_ea / ro_ea;
    v_err = V(VREF, VSS) - V(FB_IN, VSS);

    // Error amplifier stage (PMOS-mirror load referenced to VDD so vg tracks VDD at DC):
    //   VOUT < VREF -> v_err > 0 -> +gm_ea*v_err pulls current out of vg to VSS
    //   -> vg drops -> Vsg rises -> more PMOS pass current -> VOUT rises (negative feedback)
    I(vg, VSS) <+ gm_ea * v_err
                  + c_ea * ddt(V(vg, VSS))
                  + white_noise((gm_ea * vn_ea_rt_hz) * (gm_ea * vn_ea_rt_hz), "ea_thermal");
    I(vg, VDD) <+ (V(vg, VDD) + vsg0) / ro_ea;

    // Miller compensation branch between vg and VOUT through nulling resistor r_z
    if (c_m > 0.0) begin
        if (r_z > 0.0) begin
            I(vg, vm_mid)   <+ V(vg, vm_mid) / r_z;
            I(vm_mid, VOUT) <+ c_m * ddt(V(vm_mid, VOUT));
        end else begin
            V(vm_mid, vg)   <+ 0.0;
            I(vg, VOUT)     <+ c_m * ddt(V(vg, VOUT));
        end
    end else begin
        V(vm_mid, VSS) <+ 0.0;
    end

    // PMOS pass device: source = VDD, gate = vg, drain = VOUT
    // Gives textbook DC PSRR ~= T0 and realistic HF roll-off via c_ea/c_m/C_L
    vsg_drive = V(VDD, vg) - vsg0;
    I(VDD, VOUT) <+ gm_pass * vsg_drive + V(VDD, VOUT) / ro_pass;
end

endmodule
