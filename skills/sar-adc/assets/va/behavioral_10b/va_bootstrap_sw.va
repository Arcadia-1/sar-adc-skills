// Process-independent behavioral sampling switch (bootstrapped vs. plain NMOS)
//
// Models:
//   - mode = 0 (bootstrapped): VG = VIN + vdd_eff -> constant Vgs -> flat Ron
//   - mode = 1 (plain NMOS)  : VG = vdd -> Vgs = vdd - Vmid -> signal-dependent Ron
//     causing HD2/HD3 sampling distortion on high-frequency sine inputs
//   - Smooth switch conductance transition + optional overlap clock feedthrough (c_ov)
//   - Optional sampling aperture jitter (t_jitter_rms, causal falling-edge jitter)
//   - Optional supply/common-mode feedthrough sensitivities (psrr_v_per_v, cmrr_v_per_v)
//   - VG_MON output tracks the effective gate voltage for waveform verification

`include "constants.vams"
`include "disciplines.vams"

module va_bootstrap_sw(
    input  electrical CLKS,
    input  electrical VIN,
    inout  electrical VOUT,
    output electrical VG_MON
);

parameter integer mode         = 0    from [0:1];    // 0=bootstrapped, 1=plain NMOS
parameter real    vdd          = 0.9  from (0:inf);
parameter real    vth          = 0.25 from (0:inf);  // NMOS threshold voltage [V]
parameter real    ron0         = 50.0 from (0:inf);  // nominal on-resistance at Vov = vdd-vth [ohm]
parameter real    roff         = 1e9  from (0:inf);  // off-resistance [ohm]
parameter real    c_ratio      = 0.08 from [0:0.5);  // bootstrap droop C_par/(CB+C_par)
parameter real    c_ov         = 0.0  from [0:inf);  // gate-to-output overlap cap [F]
parameter real    t_jitter_rms = 0.0  from [0:inf);  // RMS aperture jitter on CLKS fall [s]
parameter integer jitter_seed  = 1;                  // PRNG seed for aperture jitter
parameter real    tr_jit       = 15p  from (0:inf);  // jittered internal clock edge time [s]
parameter real    psrr_v_per_v = 0.0;                // supply-to-output feedthrough [V/V]
parameter real    cmrr_v_per_v = 0.0;                // input-CM offset coupling [V/V]
parameter real    vcm_nom      = 0.45;               // nominal input common-mode [V]

integer clk_st, armed_r, armed_f, armed_vdd, jseed;
real t_r_fire, t_f_fire, t_vdd_fire, t_ped, dt_jit, dly, vdd_sense;
real v_clk_jit, v_clk_eff, clk_norm, vmid, vgs_eff, vov_nom, vov_eff, ron_eff, g_sw, vg_val, v_off;

analog begin
    @(initial_step) begin
        clk_st     = (V(CLKS) > vdd/2.0) ? 1 : 0;
        armed_r    = 0;
        armed_f    = 0;
        armed_vdd  = 0;
        t_r_fire   = -1.0;
        t_f_fire   = -1.0;
        t_vdd_fire = -1.0;
        jseed      = jitter_seed;
        t_ped      = (t_jitter_rms > 0.0) ? (6.0 * t_jitter_rms) : 0.0;
        vdd_sense  = vdd;
    end

    @(cross(V(CLKS) - vdd/2.0, +1)) begin
        if (psrr_v_per_v != 0.0) begin
            armed_vdd  = 1;
            t_vdd_fire = $abstime + 100p;
        end
        if (t_jitter_rms > 0.0) begin
            armed_r  = 1;
            t_r_fire = $abstime + t_ped;
        end else begin
            clk_st = 1;
        end
    end

    @(cross(V(CLKS) - vdd/2.0, -1)) begin
        if (t_jitter_rms > 0.0) begin
            dt_jit = $rdist_normal(jseed, 0.0, t_jitter_rms);
            if (dt_jit >  5.0 * t_jitter_rms) dt_jit =  5.0 * t_jitter_rms;
            if (dt_jit < -5.0 * t_jitter_rms) dt_jit = -5.0 * t_jitter_rms;
            dly = t_ped + dt_jit;
            if (dly < 1e-15) dly = 1e-15;
            armed_f  = 1;
            t_f_fire = $abstime + dly;
        end else begin
            clk_st = 0;
        end
    end

    @(timer(t_r_fire)) begin
        if (armed_r) begin
            clk_st  = 1;
            armed_r = 0;
        end
    end

    @(timer(t_f_fire)) begin
        if (armed_f) begin
            clk_st  = 0;
            armed_f = 0;
        end
    end

    @(timer(t_vdd_fire)) begin
        if (armed_vdd) begin
            if (V(CLKS) > 0.5 * vdd) begin
                vdd_sense = V(CLKS);
            end
            armed_vdd = 0;
        end
    end

    v_clk_jit = transition(clk_st * vdd, 0, tr_jit, tr_jit);
    v_clk_eff = (t_jitter_rms > 0.0) ? v_clk_jit : V(CLKS);

    // Smooth normalized clock weight in [0, 1]
    clk_norm = 0.5 * (1.0 + tanh((v_clk_eff - vdd/2.0) / (0.05 * vdd)));
    vmid     = 0.5 * (V(VIN) + V(VOUT));
    vov_nom  = max(vdd - vth, 0.05);

    if (mode == 0) begin
        // Bootstrapped gate: VG = (1 - c_ratio)*vdd_sense + VIN during ON
        vg_val  = clk_norm * ((1.0 - c_ratio) * vdd_sense + V(VIN));
        vgs_eff = (1.0 - c_ratio) * vdd_sense;
    end else begin
        // Plain NMOS gate: VG = vdd_sense during ON -> Vgs shrinks with input voltage
        vg_val  = clk_norm * vdd_sense;
        vgs_eff = vdd_sense - vmid;
    end

    // Smoothly floored overdrive so Ron stays physical across the full rail
    vov_eff = 0.5 * ((vgs_eff - vth) + sqrt((vgs_eff - vth)*(vgs_eff - vth) + 1e-4));
    ron_eff = ron0 * (vov_nom / max(vov_eff, 1e-3));
    g_sw    = clk_norm / ron_eff + (1.0 - clk_norm) / roff;

    v_off = psrr_v_per_v * (vdd_sense - vdd) + cmrr_v_per_v * (V(VIN) - vcm_nom);
    I(VIN, VOUT) <+ g_sw * (V(VIN) + v_off - V(VOUT));
    V(VG_MON)    <+ vg_val;

    if (c_ov > 0.0) begin
        I(VOUT) <+ c_ov * ddt(V(VOUT) - vg_val);
    end
end

endmodule
