// Process-independent 10-bit asynchronous SAR logic
//
// Event sequence per conversion cycle:
//   1. CLKS rising  : reset internal DAC controls (DCTRLP/DCTRLN = 0), CMPCK = 0,
//                     EOC = 0, step = 9. Previous latched DOUT[9:0] stays stable!
//   2. CLKS falling : after t_start_delay, assert CMPCK = 1 for MSB (step = 9).
//   3. Comparator decision (DCMPP or DCMPN rises > vdd/2):
//        - Capture bit into internal shift register bit_reg[step]
//        - Drive DCTRLN[step]=1 (if bit=1) or DCTRLP[step]=1 (if bit=0) for step >= 1
//        - Schedule CMPCK = 0 after t_valid_to_rst
//   4. Comparator reset complete (both DCMPP and DCMPN <= vdd/2):
//        - If step > 0 : decrement step and schedule next CMPCK = 1 after t_rst_to_cmp
//                        (models reset + CDAC settling guard time)
//        - If step == 0: latch bit_reg[9:0] -> DOUT[9:0] and assert EOC = 1
//                        (NOR3 completion stop: zero spurious CMPCK pulses after LSB)

`include "constants.vams"
`include "disciplines.vams"

module va_sar_logic_10b_async(
    input  electrical       CLKS,
    input  electrical       DCMPP,
    input  electrical       DCMPN,
    output electrical       CMPCK,
    output electrical       EOC,
    output electrical [9:0] DOUT,
    output electrical [9:1] DCTRLP,
    output electrical [9:1] DCTRLN
);

parameter real vdd            = 0.9  from (0:inf);
parameter real t_start_delay  = 150p from [0:inf);  // CLKS falling -> 1st CMPCK rising
parameter real t_valid_to_rst = 60p  from [0:inf);  // VALID rising -> CMPCK falling
parameter real t_rst_to_cmp   = 250p from [0:inf);  // comparator reset + DAC settle wait
parameter real tr             = 15p  from (0:inf);  // logic transition time

integer step, active, cmpck_st, eoc_st, decided;
integer bit_reg[9:0], dout_reg[9:0];
integer dctrlp_reg[9:1], dctrln_reg[9:1];
integer armed_cmp_hi, armed_cmp_lo;
real t_cmp_hi, t_cmp_lo;
genvar i;

analog begin
    @(initial_step) begin
        step         = 9;
        active       = 0;
        cmpck_st     = 0;
        eoc_st       = 0;
        decided      = 0;
        armed_cmp_hi = 0;
        armed_cmp_lo = 0;
        t_cmp_hi     = -1.0;
        t_cmp_lo     = -1.0;
        for (i = 0; i <= 9; i = i + 1) begin
            bit_reg[i]  = 0;
            dout_reg[i] = 0;
        end
        for (i = 1; i <= 9; i = i + 1) begin
            dctrlp_reg[i] = 0;
            dctrln_reg[i] = 0;
        end
    end

    // Sampling phase: reset state machine and CDAC controls; keep DOUT latched
    @(cross(V(CLKS) - vdd/2, +1)) begin
        step         = 9;
        active       = 0;
        cmpck_st     = 0;
        eoc_st       = 0;
        decided      = 0;
        armed_cmp_hi = 0;
        armed_cmp_lo = 0;
        for (i = 0; i <= 9; i = i + 1) begin
            bit_reg[i] = 0;
        end
        for (i = 1; i <= 9; i = i + 1) begin
            dctrlp_reg[i] = 0;
            dctrln_reg[i] = 0;
        end
    end

    // End of sampling: launch MSB comparison
    @(cross(V(CLKS) - vdd/2, -1)) begin
        active       = 1;
        step         = 9;
        decided      = 0;
        eoc_st       = 0;
        armed_cmp_lo = 0;
        if (t_start_delay > 0.0) begin
            armed_cmp_hi = 1;
            t_cmp_hi     = $abstime + t_start_delay;
        end else begin
            cmpck_st     = 1;
            armed_cmp_hi = 0;
        end
    end

    // Comparator decision detected (VALID rising)
    @(cross(V(DCMPP) - vdd/2, +1) or cross(V(DCMPN) - vdd/2, +1)) begin
        if (active && !decided && step >= 0 && step <= 9) begin
            decided = 1;
            bit_reg[step] = (V(DCMPP) >= V(DCMPN)) ? 1 : 0;

            if (step >= 1) begin
                if (bit_reg[step] == 1) begin
                    dctrln_reg[step] = 1;
                end else begin
                    dctrlp_reg[step] = 1;
                end
            end

            if (t_valid_to_rst > 0.0) begin
                armed_cmp_lo = 1;
                t_cmp_lo     = $abstime + t_valid_to_rst;
            end else begin
                cmpck_st     = 0;
                armed_cmp_lo = 0;
            end
        end
    end

    // Comparator reset finished (VALID falling): advance to next bit or assert EOC
    @(cross(V(DCMPP) - vdd/2, -1) or cross(V(DCMPN) - vdd/2, -1)) begin
        if (active && decided && V(DCMPP) <= vdd/2 && V(DCMPN) <= vdd/2) begin
            decided = 0;
            if (step > 0) begin
                step = step - 1;
                if (t_rst_to_cmp > 0.0) begin
                    armed_cmp_hi = 1;
                    t_cmp_hi     = $abstime + t_rst_to_cmp;
                end else begin
                    cmpck_st     = 1;
                    armed_cmp_hi = 0;
                end
            end else begin
                // Conversion complete: latch full 10-bit word and halt CMPCK
                for (i = 0; i <= 9; i = i + 1) begin
                    dout_reg[i] = bit_reg[i];
                end
                active       = 0;
                cmpck_st     = 0;
                eoc_st       = 1;
                armed_cmp_hi = 0;
                armed_cmp_lo = 0;
            end
        end
    end

    @(timer(t_cmp_hi)) begin
        if (armed_cmp_hi && active && !eoc_st && V(CLKS) <= vdd/2) begin
            cmpck_st     = 1;
            armed_cmp_hi = 0;
        end
    end

    @(timer(t_cmp_lo)) begin
        if (armed_cmp_lo) begin
            cmpck_st     = 0;
            armed_cmp_lo = 0;
        end
    end

    V(CMPCK) <+ transition(cmpck_st * vdd, 0, tr, tr);
    V(EOC)   <+ transition(eoc_st   * vdd, 0, tr, tr);

    for (i = 1; i <= 9; i = i + 1) begin
        V(DCTRLP[i]) <+ transition(dctrlp_reg[i] * vdd, 0, tr, tr);
        V(DCTRLN[i]) <+ transition(dctrln_reg[i] * vdd, 0, tr, tr);
    end
    for (i = 0; i <= 9; i = i + 1) begin
        V(DOUT[i]) <+ transition(dout_reg[i] * vdd, 0, tr, tr);
    end
end

endmodule
