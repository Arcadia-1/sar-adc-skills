`include "constants.vams"
`include "disciplines.vams"

`define NUM_ADC_BITS 4
`default_transition 10p

module L3_logic_4b_async(
    input  electrical                       CLKC,
    input  electrical                       CLKS,
    input  electrical                       DCMPP,
    input  electrical                       DCMPN,
    output electrical                       CMPCK,
    output electrical [`NUM_ADC_BITS-1:0]   DO,
    output electrical [`NUM_ADC_BITS-1:1]   DCTRLP,
    output electrical [`NUM_ADC_BITS-1:1]   DCTRLN
);

parameter real vdd = 1, t_logic_delay = 200p;
integer step, cmpck;
integer dout[`NUM_ADC_BITS-1:0], dctrlp[`NUM_ADC_BITS-1:1], dctrln[`NUM_ADC_BITS-1:1];
genvar i;

analog begin
    // Initialize and reset when CLKS rises
    @(initial_step or cross(V(CLKS) - vdd/2, +1)) begin
        step = `NUM_ADC_BITS - 1;
        cmpck = 0;
        for (i = 1; i <= `NUM_ADC_BITS - 1; i = i + 1) begin
            dctrlp[i] = 0;
            dctrln[i] = 0;
        end
        for (i = 0; i <= `NUM_ADC_BITS - 1; i = i + 1) begin
            dout[i] = 0;
        end
    end

    // Start first SAR comparison
    @(cross(V(CLKC) - vdd/2, +1)) begin
        cmpck = 1;
    end

    // 1) Comparator decision arrived
    @(cross(V(DCMPP) - vdd/2, +1) or cross(V(DCMPN) - vdd/2, +1)) begin
        cmpck = 0;

        if (step >= 0 && step < `NUM_ADC_BITS) begin
            dout[step] = (V(DCMPP) >= V(DCMPN)) ? 1 : 0;
        end

        if (step >= 1 && step < `NUM_ADC_BITS) begin
            if (dout[step] == 1) begin
                dctrln[step] = 1;
            end else begin
                dctrlp[step] = 1;
            end
        end
    end

    // 2) Comparator finished resetting -> advance to next bit
    @(cross(V(DCMPP) - vdd/2, -1) or cross(V(DCMPN) - vdd/2, -1)) begin
        step = step - 1;
        if (step >= 0) begin
            cmpck = 1;
        end
    end

    V(CMPCK) <+ transition(cmpck * vdd, t_logic_delay);

    for (i = 1; i <= `NUM_ADC_BITS - 1; i = i + 1) begin
        V(DCTRLP[i]) <+ transition(dctrlp[i] * vdd);
        V(DCTRLN[i]) <+ transition(dctrln[i] * vdd);
    end

    for (i = 0; i <= `NUM_ADC_BITS - 1; i = i + 1) begin
        V(DO[i]) <+ transition(dout[i] * vdd);
    end
end

endmodule
