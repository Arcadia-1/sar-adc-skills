// =============================================================================
// Process-Independent Full SAR ADC Testbench — Ramp Linearity & Usable Swing
// =============================================================================
// Drives a slow differential linear ramp spanning slightly beyond full scale
// ([-overdrive*vref, +overdrive*vref]) to check in a single fast transient run:
//   - True usable full-scale input range (detects early clipping from C_par)
//   - Missing codes across [1 .. 2^N - 2]
//   - Histogram-based static DNL / INL (set hits_per_code >= 4 for fine accuracy)
//
// DUT interface contract:
//   subckt dut_sar_adc VIP VIN CLKS \
//       DOUT9 DOUT8 DOUT7 DOUT6 DOUT5 DOUT4 DOUT3 DOUT2 DOUT1 DOUT0 \
//       VDD VSS
// =============================================================================

simulator lang=spectre
global 0

include "models_corner.scs"
include "dut_subckt.scs"
ahdl_include "../../va/behavioral_10b/va_dac_10b_diff.va"

parameters \
    vdd=0.9 \
    vref=0.9 \
    vcm=0.45 \
    overdrive=1.04 \
    fs=50M \
    hits_per_code=4 \
    n_codes=1024 \
    n_settle=2 \
    duty_track=0.20 \
    tr=15p \
    tf=15p \
    temp_c=27

parameters \
    ts=1/fs \
    n_ramp=hits_per_code*n_codes \
    t_settle=n_settle*ts \
    t_ramp=n_ramp*ts \
    t_stop=t_settle+t_ramp+2*ts \
    v_half_span=0.5*overdrive*vref

VSUP  (VDD 0)  vsource dc=vdd type=dc
VGND  (VSS 0)  vsource dc=0   type=dc
VCLKS (CLKS 0) vsource type=pulse val0=0 val1=vdd \
    period=ts delay=0 rise=tr fall=tf width=duty_track*ts

// Linear ramp from -overdrive*vref to +overdrive*vref over [t_settle, t_settle + t_ramp]
VVIP (VIP 0) vsource type=pwl wave=[ \
    0               (vcm-v_half_span) \
    t_settle        (vcm-v_half_span) \
    (t_settle+t_ramp) (vcm+v_half_span) \
    t_stop          (vcm+v_half_span) ]
VVIN (VIN 0) vsource type=pwl wave=[ \
    0               (vcm+v_half_span) \
    t_settle        (vcm+v_half_span) \
    (t_settle+t_ramp) (vcm-v_half_span) \
    t_stop          (vcm-v_half_span) ]

I0 (VIP VIN CLKS \
    DOUT9 DOUT8 DOUT7 DOUT6 DOUT5 DOUT4 DOUT3 DOUT2 DOUT1 DOUT0 \
    VDD VSS) dut_sar_adc

I_DAC (DOUT9 DOUT8 DOUT7 DOUT6 DOUT5 DOUT4 DOUT3 DOUT2 DOUT1 DOUT0 \
    CLKS AOUT CODE) va_dac_10b_diff vdd=vdd vth=0.5*vdd vref=vref

simulatorOptions options psfversion="1.4.0" \
    reltol=1e-4 vabstol=1e-7 iabstol=1e-13 \
    temp=temp_c tnom=27 gmin=1e-12 rforce=1 maxnotes=5 maxwarns=5

// Strobe 0.1*ts after each CLKS rising edge (strobedelay < strobeperiod)
tran tran stop=t_stop errpreset=moderate \
    strobeperiod=ts strobedelay=0.1*ts strobeoutput=strobeonly

save CODE AOUT VIP VIN
saveOptions options save=selected
