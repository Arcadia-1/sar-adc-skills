// =============================================================================
// Process-Independent Full SAR ADC Testbench — Transient Noise FFT & Histogram
// =============================================================================
// Performs dual thermal-noise verification in one Spectre run:
//   1. `tran_fft`  : coherent single-tone FFT with transient noise enabled
//                    (and/or behavioral kT/C + comparator noise), verifying
//                    measured SNR/ENOB against analytical budget
//                    SNR_theory = 10*log10(P_sig / (P_q + P_kTC + P_cmp))
//   2. `tran_hist` : grounded-input (`a_in_ratio = 0`) multi-sample code
//                    histogram (`n_hist >= 256`, default 512) extracting total
//                    RMS noise (`sigma_total_lsb`, `sigma_in_uvrms`) & offset
//
// Recommended Spectre X invocation:
//   spectre +preset=ax +mt=2 -format psfascii ...
//   (Always keep noiseruns=1 and strobeoutput=strobeonly!)
//
// DUT interface contract (10-bit fully differential SAR ADC):
//   subckt dut_sar_adc VIP VIN CLKS \
//       DOUT9 DOUT8 DOUT7 DOUT6 DOUT5 DOUT4 DOUT3 DOUT2 DOUT1 DOUT0 \
//       VDD VSS
// =============================================================================

simulator lang=spectre
global 0

include "models_corner.scs"
include "dut_subckt.scs"
ahdl_include "../../va/behavioral_10b/va_dac_10b_diff.va"

parameters \
    vdd=0.9 \
    vref=0.9 \
    vcm=0.45 \
    a_in_ratio=0.90 \
    fs=50M \
    n_fft=256 \
    m_bin=43 \
    n_hist=512 \
    n_settle=4 \
    duty_track=0.20 \
    tr=15p \
    tf=15p \
    fmax_noise=500M \
    fmin_noise=50k \
    noise_seed=11 \
    temp_c=27

parameters \
    ts=1/fs \
    fin=fs*m_bin/n_fft \
    t_stop_fft=(n_settle+n_fft+1)*ts \
    t_stop_hist=(n_settle+n_hist+1)*ts

VSUP  (VDD 0)  vsource dc=vdd type=dc
VGND  (VSS 0)  vsource dc=0   type=dc
VCLKS (CLKS 0) vsource type=pulse val0=0 val1=vdd \
    period=ts delay=0 rise=tr fall=tf width=duty_track*ts

// Expression directly on instance so `alter param=a_in_ratio value=0` zeroes stimulus
VVIP (VIP 0) vsource type=sine sinedc=vcm ampl=0.5*a_in_ratio*vref  freq=fin
VVIN (VIN 0) vsource type=sine sinedc=vcm ampl=-0.5*a_in_ratio*vref freq=fin

I0 (VIP VIN CLKS \
    DOUT9 DOUT8 DOUT7 DOUT6 DOUT5 DOUT4 DOUT3 DOUT2 DOUT1 DOUT0 \
    VDD VSS) dut_sar_adc

I_DAC (DOUT9 DOUT8 DOUT7 DOUT6 DOUT5 DOUT4 DOUT3 DOUT2 DOUT1 DOUT0 \
    CLKS AOUT CODE) va_dac_10b_diff vdd=vdd vth=0.5*vdd vref=vref

simulatorOptions options psfversion="1.4.0" \
    reltol=1e-4 vabstol=1e-7 iabstol=1e-13 \
    temp=temp_c tnom=27 gmin=1e-12 rforce=1 maxnotes=5 maxwarns=5

// 1) Coherent sine FFT with transient noise enabled (noiseruns=1!)
tran_fft tran stop=t_stop_fft errpreset=moderate \
    noisefmax=fmax_noise noisefmin=fmin_noise noiseseed=noise_seed \
    noisescale=1 noiseruns=1 \
    strobeperiod=ts strobedelay=0.1*ts strobeoutput=strobeonly

// 2) Grounded-input (V_id = 0) multi-sample code histogram
alt_gnd alter param=a_in_ratio value=0

tran_hist tran stop=t_stop_hist errpreset=moderate \
    noisefmax=fmax_noise noisefmin=fmin_noise noiseseed=noise_seed+100 \
    noisescale=1 noiseruns=1 \
    strobeperiod=ts strobedelay=0.1*ts strobeoutput=strobeonly

save CODE AOUT VIP VIN
saveOptions options save=selected
