// =============================================================================
// Process-Independent Full SAR ADC Testbench — Input Driver & Anti-Aliasing RC
// =============================================================================
// Co-simulates a finite-bandwidth, slew-limited analog input buffer
// (`va_input_driver.va`) and anti-aliasing RC filter (`r_aa`, `c_ext`) driving
// the clocked SAR ADC sampling switch and `C_dac` (with real acquisition-start
// charge kickback from the converged CDAC residue `VCM`).
//
// An identical unloaded reference driver + AA filter (`VIP_REF`, `VIN_REF`)
// runs in parallel so acquisition-end kickback settling error right before
// `CLKS` falls is isolated cleanly without linear RC group-delay pollution:
//   v_err_acq = (V(VIP) - V(VIN)) - (V(VIP_REF) - V(VIN_REF))
//
// Uses Spectre `alter` to compare:
//   1. `tran_under` : undersized driver/RC -> large settling error & HD3/ENOB drop
//   2. `tran_sized` : properly sized driver/RC -> <0.25 LSB settle & full ENOB
//
// Note for transistor-level DUTs with an internal charge-drawing CDAC:
//   set `c_dac_ext=0 rst_en=0 r_sw_ext=1m` so the external behavioral kickback
//   load is bypassed and the DUT's own CDAC loads `VIP_PIN`/`VIN_PIN` directly.
//
// DUT interface contract (10-bit fully differential SAR ADC):
//   subckt dut_sar_adc VIP VIN CLKS \
//       DOUT9 DOUT8 DOUT7 DOUT6 DOUT5 DOUT4 DOUT3 DOUT2 DOUT1 DOUT0 \
//       VDD VSS
// =============================================================================

simulator lang=spectre
global 0

include "models_corner.scs"
include "dut_subckt.scs"
ahdl_include "../../va/behavioral_10b/va_dac_10b_diff.va"
ahdl_include "../../va/behavioral_10b/va_input_driver.va"

parameters \
    vdd=0.9 \
    vref=0.9 \
    vcm=0.45 \
    a_in_ratio=0.90 \
    fs=50M \
    n_fft=128 \
    m_bin=19 \
    n_settle=4 \
    duty_track=0.20 \
    tr=15p \
    tf=15p \
    c_dac_ext=500f \
    r_sw_ext=15 \
    rst_en=1 \
    f_drv=25M \
    r_drv=60 \
    i_max_drv=80u \
    r_aa=250 \
    c_ext=2p \
    f_drv_ok=600M \
    r_drv_ok=5 \
    i_max_ok=20m \
    r_aa_ok=10 \
    c_ext_ok=10p \
    temp_c=27

parameters \
    ts=1/fs \
    fin=fs*m_bin/n_fft \
    amp_se=0.5*a_in_ratio*vref \
    t_acq=duty_track*ts \
    t_stop=(n_settle+n_fft+1)*ts

VSUP  (VDD 0)  vsource dc=vdd type=dc
VGND  (VSS 0)  vsource dc=0   type=dc
VVCM  (VCM_N 0) vsource dc=vcm type=dc

VCLKS (CLKS 0) vsource type=pulse val0=0 val1=vdd \
    period=ts delay=0 rise=tr fall=tf width=t_acq

// Non-overlapping hold-phase reset pulse (resets external C_dac model to Vcm)
VCLKR (CLKS_RST 0) vsource type=pulse val0=0 val1=rst_en*vdd \
    period=ts delay=0.5*ts rise=tr fall=tf width=0.3*ts

// Ideal coherent differential sine source before input driver
VSRCP (SRC_P 0) vsource type=sine sinedc=vcm ampl=amp_se  freq=fin
VSRCN (SRC_N 0) vsource type=sine sinedc=vcm ampl=-amp_se freq=fin

// Active input driver + anti-aliasing RC network
I_DRVP (SRC_P DRV_P VSS) va_input_driver f_bw=f_drv r_out=r_drv i_max=i_max_drv
I_DRVN (SRC_N DRV_N VSS) va_input_driver f_bw=f_drv r_out=r_drv i_max=i_max_drv

R_AAP  (DRV_P VIP_PIN) resistor  r=r_aa
R_AAN  (DRV_N VIN_PIN) resistor  r=r_aa
C_EXTP (VIP_PIN 0)     capacitor c=c_ext
C_EXTN (VIN_PIN 0)     capacitor c=c_ext

// Clocked sampling switch & CDAC charge-kickback load (bypassable via c_dac_ext=0)
model sw_acq relay rclosed=r_sw_ext ropen=1e10 vt1=0.35*vdd vt2=0.65*vdd
model sw_rst relay rclosed=20       ropen=1e10 vt1=0.35*vdd vt2=0.65*vdd
S_ACQP (VIP_PIN VIP CLKS     0) sw_acq
S_ACQN (VIN_PIN VIN CLKS     0) sw_acq
S_RSTP (VIP   VCM_N CLKS_RST 0) sw_rst
S_RSTN (VIN   VCM_N CLKS_RST 0) sw_rst
C_DACP (VIP 0) capacitor c=c_dac_ext
C_DACN (VIN 0) capacitor c=c_dac_ext

// Unloaded matched reference driver + AA filter (isolates pure kickback settling error)
I_DRVP_REF (SRC_P DRV_PR VSS) va_input_driver f_bw=f_drv r_out=r_drv i_max=i_max_drv
I_DRVN_REF (SRC_N DRV_NR VSS) va_input_driver f_bw=f_drv r_out=r_drv i_max=i_max_drv
R_AAPR  (DRV_PR VIP_REF) resistor  r=r_aa
R_AANR  (DRV_NR VIN_REF) resistor  r=r_aa
C_EXTPR (VIP_REF 0)      capacitor c=c_ext
C_EXTNR (VIN_REF 0)      capacitor c=c_ext

I0 (VIP VIN CLKS \
    DOUT9 DOUT8 DOUT7 DOUT6 DOUT5 DOUT4 DOUT3 DOUT2 DOUT1 DOUT0 \
    VDD VSS) dut_sar_adc

I_DAC (DOUT9 DOUT8 DOUT7 DOUT6 DOUT5 DOUT4 DOUT3 DOUT2 DOUT1 DOUT0 \
    CLKS AOUT CODE) va_dac_10b_diff vdd=vdd vth=0.5*vdd vref=vref

simulatorOptions options psfversion="1.4.0" \
    reltol=1e-4 vabstol=1e-7 iabstol=1e-13 \
    temp=temp_c tnom=27 gmin=1e-12 rforce=1 maxnotes=5 maxwarns=5

// Strobe 20 ps before CLKS falls (captures BOTH settled previous CODE and
// exact acquisition-end voltage right before sampling instant!)
tran_under tran stop=t_stop errpreset=conservative \
    strobeperiod=ts strobedelay=t_acq-20p strobeoutput=strobeonly

// Switch to properly sized input driver & anti-aliasing RC network
alt_f    alter param=f_drv     value=f_drv_ok
alt_r    alter param=r_drv     value=r_drv_ok
alt_imax alter param=i_max_drv value=i_max_ok
alt_raa  alter param=r_aa      value=r_aa_ok
alt_cext alter param=c_ext     value=c_ext_ok

tran_sized tran stop=t_stop errpreset=conservative \
    strobeperiod=ts strobedelay=t_acq-20p strobeoutput=strobeonly

save CODE AOUT VIP VIN VIP_PIN VIN_PIN VIP_REF VIN_REF
saveOptions options save=selected
