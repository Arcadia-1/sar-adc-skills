// =============================================================================
// Process-Independent Integer-N CP-PLL — Closed-Loop Noise Budget & N x ICP Matrix
// =============================================================================
// Instant (< 1 s) phase-domain Spectre `noise` + 9-point `stb` signoff deck:
//   Part A — Closed-loop phase noise L(df) [1 kHz .. 100 MHz], integrated RMS
//            jitter [10 kHz .. 30 MHz], and exact per-block noise breakdown (%)
//            for Ref/Div, Charge Pump, Loop-Filter R1 (native 4kTR), and VCO.
//   Part B — 9-point programmable N x I_CP loop stability matrix via `alter` +
//            `stb` (N in {16, 32, 64} x I_CP in {80u, 160u, 320u}), verifying
//            constant f_u along I_CP / N = const and flagging low-PM corners.
//
// Phase-domain scaling: 1 V at PHI_OUT == 1 rad; L(f) = 10*log10(out^2 / 2).
// =============================================================================

simulator lang=spectre
global 0

parameters \
    i_cp=160u \
    kvco=200e6 \
    n_div=32 \
    r1=13.5k \
    c1=22p \
    c2=1.7p \
    en_ref=1 \
    en_cp=1 \
    en_vco=1 \
    pi=3.141592653589793

// Calibrated independent phase/current noise sources (double-sided PSDs):
//   Ref/Div : L_in = -148 dBc/Hz white, 10 kHz 1/f corner  -> S_phi [rad^2/Hz]
//   CP      : S_I  = 5.0e-24 A^2/Hz white, 50 kHz 1/f corner -> [A^2/Hz]
//   VCO     : L(1M)= -118 dBc/Hz (1/f^2), 150 kHz 1/f^3 corner -> S_phi [rad^2/Hz]
V_N_REF (N_REF_SRC 0) vsource dc=0 noisevec=[ \
    1k 3.487e-14 10k 6.340e-15 100k 3.487e-15 1M 3.202e-15 100M 3.170e-15 ]
V_N_CP  (N_CP_SRC  0) vsource dc=0 noisevec=[ \
    1k 2.550e-22 10k 3.000e-23 50k 1.000e-23 500k 5.500e-24 100M 5.000e-24 ]
V_N_VCO (N_VCO_SRC 0) vsource dc=0 noisevec=[ \
    1k 4.787e-4 10k 5.072e-7 50k 5.072e-9 150k 2.818e-10 \
    500k 1.648e-11 1M 3.646e-12 10M 3.218e-14 100M 3.175e-16 ]

// Gated noise injectors (en_* toggled in Part A for exact per-block breakdown)
E_N_REF (PHI_REF 0 N_REF_SRC 0) vcvs gain=en_ref
G_N_CP  (0 VCTRL N_CP_SRC 0)    vccs gm=en_cp

// PFD + CP phase gain Kd = I_cp / (2*pi) [A/rad]
G_CP  (0 VCTRL PHI_REF PHI_FB) vccs gm=i_cp/(2*pi)

// Passive 2nd-order loop filter (R_1 generates native 4kTR thermal noise)
R_1   (VCTRL N_C1) resistor  r=r1 isnoisy=yes
C_1   (N_C1  0)    capacitor c=c1
C_2   (VCTRL 0)    capacitor c=c2
R_DC1 (VCTRL 0)    resistor  r=1e12 isnoisy=no

// VCO phase integrator + additive free-running VCO phase noise
G_VCO   (0 PHI_VCO_INT VCTRL 0) vccs gm=2*pi*kvco
C_INT   (PHI_VCO_INT 0)         capacitor c=1.0
R_DC2   (PHI_VCO_INT 0)         resistor  r=1e12 isnoisy=no
E_N_VCO (PHI_OUT PHI_VCO_INT N_VCO_SRC 0) vcvs gain=en_vco

// Feedback divider (1/N) and loop stability probe
E_DIV (PHI_DIV 0 PHI_OUT 0) vcvs gain=1.0/n_div
IPRB  (PHI_DIV PHI_FB)      iprobe

simulatorOptions options psfversion="1.4.0" reltol=1e-5 temp=27 tnom=27 gmin=1e-12

// ---- Part A: Closed-loop phase noise budget at nominal (N=32, I_CP=160u) ----
noise_tot (PHI_OUT 0) noise start=1k stop=100M dec=25 annotate=status
alt_r1_1  alter param=en_ref value=0
alt_r1_2  alter param=en_cp  value=0
alt_r1_3  alter param=en_vco value=0
noise_r1  (PHI_OUT 0) noise start=1k stop=100M dec=25 annotate=status
alt_cp_on alter param=en_cp  value=1
noise_cp  (PHI_OUT 0) noise start=1k stop=100M dec=25 annotate=status
alt_cp_0  alter param=en_cp  value=0
alt_vco_1 alter param=en_vco value=1
noise_vco (PHI_OUT 0) noise start=1k stop=100M dec=25 annotate=status
alt_vco_0 alter param=en_vco value=0
alt_ref_1 alter param=en_ref value=1
noise_ref (PHI_OUT 0) noise start=1k stop=100M dec=25 annotate=status

// ---- Part B: 9-point programmable N x I_CP loop stability matrix ----
alt_n16_1  alter param=n_div value=16
alt_i80_1  alter param=i_cp  value=80u
stb_n16_i80  stb start=1k stop=100M dec=30 probe=IPRB annotate=status
alt_i160_1 alter param=i_cp  value=160u
stb_n16_i160 stb start=1k stop=100M dec=30 probe=IPRB annotate=status
alt_i320_1 alter param=i_cp  value=320u
stb_n16_i320 stb start=1k stop=100M dec=30 probe=IPRB annotate=status

alt_n32_2  alter param=n_div value=32
alt_i80_2  alter param=i_cp  value=80u
stb_n32_i80  stb start=1k stop=100M dec=30 probe=IPRB annotate=status
alt_i160_2 alter param=i_cp  value=160u
stb_n32_i160 stb start=1k stop=100M dec=30 probe=IPRB annotate=status
alt_i320_2 alter param=i_cp  value=320u
stb_n32_i320 stb start=1k stop=100M dec=30 probe=IPRB annotate=status

alt_n64_3  alter param=n_div value=64
alt_i80_3  alter param=i_cp  value=80u
stb_n64_i80  stb start=1k stop=100M dec=30 probe=IPRB annotate=status
alt_i160_3 alter param=i_cp  value=160u
stb_n64_i160 stb start=1k stop=100M dec=30 probe=IPRB annotate=status
alt_i320_3 alter param=i_cp  value=320u
stb_n64_i320 stb start=1k stop=100M dec=30 probe=IPRB annotate=status
