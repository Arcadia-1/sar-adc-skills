// =============================================================================
// Process-Independent Frequency Divider / MMD Testbench (Integer & Frac-N)
// =============================================================================
// Drives `dut_divider` with a clean high-speed clock at `f_in` and verifies:
//   - Exact time-averaged division ratio N_avg (supports both Integer-N and
//     Fractional-N MASH 1-1-1 Multi-Modulus Dividers!)
//   - Per-cycle instantaneous division ratio min/max/std (modulus span check)
//   - Zero skipped or glitched divided edges
//
// DUT interface contract (4-pin frequency divider or MMD):
//   subckt dut_divider CLK_IN CLK_OUT VDD VSS
// =============================================================================

simulator lang=spectre
global 0

include "models_corner.scs"
include "dut_subckt.scs"

parameters \
    vdd=0.9 \
    f_in=1.0G \
    t_stop=6u \
    tr=15p \
    tf=15p \
    temp_c=27

parameters t_in=1/f_in

VSUP (VDD 0)    vsource dc=vdd type=dc
VGND (VSS 0)    vsource dc=0   type=dc
VCLK (CLK_IN 0) vsource type=pulse val0=0 val1=vdd \
    period=t_in delay=0 rise=tr fall=tf width=0.5*t_in

I0 (CLK_IN CLK_OUT VDD VSS) dut_divider

simulatorOptions options psfversion="1.4.0" \
    reltol=1e-4 vabstol=1e-7 iabstol=1e-13 \
    temp=temp_c tnom=27 gmin=1e-12 rforce=1 maxnotes=5 maxwarns=5

tran tran stop=t_stop errpreset=moderate

save CLK_OUT
saveOptions options save=selected
