// =============================================================================
// Process-Independent VCO Testbench — Multi-Sub-Band Cap-Bank Overlap & K_LIN
// =============================================================================
// Sweeps 8 coarse switched-capacitor sub-bands (VCODE = 0..7 via `alter`) and
// steps VCTRL across 7 levels per band from vctrl_min to vctrl_max, measuring
// settled oscillation frequency via `va_phase_err_mon.va`.
//
// Extracts (via `analyze_vco.py capbank`):
//   - Per-sub-band f_min, f_max, K_VCO [MHz/V], and endpoint linearity K_LIN [%]
//   - Adjacent sub-band overlap [%] = (f_max[k] - f_min[k+1]) / f_step * 100
//   - Continuous tuning coverage & blind-hole detection (overlap_pass >= 20%)
//
// DUT interface contract (6-pin multi-sub-band differential VCO):
//   subckt dut_vco_mb VCTRL VCODE OUTP OUTN VDD VSS
// =============================================================================

simulator lang=spectre
global 0

include "models_corner.scs"
include "dut_subckt.scs"
ahdl_include "../../va/va_phase_err_mon.va"

parameters \
    vdd=0.9 \
    vctrl_min=0.20 \
    vctrl_max=0.70 \
    v_code=0 \
    n_pts=7 \
    t_dwell=25n \
    f_init=1.6G \
    temp_c=27

parameters \
    t_stop=n_pts*t_dwell \
    v_step=(vctrl_max-vctrl_min)/(n_pts-1)

VSUP   (VDD 0)   vsource dc=vdd    type=dc
VGND   (VSS 0)   vsource dc=0      type=dc
VBCODE (VCODE 0) vsource dc=v_code type=dc

// 7-point VCTRL staircase across usable varactor compliance window
VVCTRL (VCTRL 0) vsource type=pwl wave=[ \
    0               vctrl_min                (1*t_dwell-0.5n) vctrl_min \
    (1*t_dwell)     (vctrl_min+1*v_step)     (2*t_dwell-0.5n) (vctrl_min+1*v_step) \
    (2*t_dwell)     (vctrl_min+2*v_step)     (3*t_dwell-0.5n) (vctrl_min+2*v_step) \
    (3*t_dwell)     (vctrl_min+3*v_step)     (4*t_dwell-0.5n) (vctrl_min+3*v_step) \
    (4*t_dwell)     (vctrl_min+4*v_step)     (5*t_dwell-0.5n) (vctrl_min+4*v_step) \
    (5*t_dwell)     (vctrl_min+5*v_step)     (6*t_dwell-0.5n) (vctrl_min+5*v_step) \
    (6*t_dwell)     vctrl_max                t_stop           vctrl_max ]

// Brief initial kick pulse to guarantee startup of symmetric LC tanks
IKICK (OUTP OUTN) isource type=pulse val0=0 val1=100u delay=0 rise=10p fall=10p width=0.2n

I0    (VCTRL VCODE OUTP OUTN VDD VSS) dut_vco_mb
I_MON (OUTP F_INST T_PER) va_phase_err_mon vth=0.5*vdd f_init=f_init

simulatorOptions options psfversion="1.4.0" \
    reltol=1e-4 vabstol=1e-7 iabstol=1e-13 \
    temp=temp_c tnom=27 gmin=1e-12 rforce=1 maxnotes=5 maxwarns=5

// Sweep 8 coarse sub-bands (codes 0..7), strobing near end of each VCTRL dwell
tran_b0 tran stop=t_stop errpreset=moderate strobeperiod=t_dwell strobedelay=0.9*t_dwell strobeoutput=strobeonly
alt_b1  alter param=v_code value=1
tran_b1 tran stop=t_stop errpreset=moderate strobeperiod=t_dwell strobedelay=0.9*t_dwell strobeoutput=strobeonly
alt_b2  alter param=v_code value=2
tran_b2 tran stop=t_stop errpreset=moderate strobeperiod=t_dwell strobedelay=0.9*t_dwell strobeoutput=strobeonly
alt_b3  alter param=v_code value=3
tran_b3 tran stop=t_stop errpreset=moderate strobeperiod=t_dwell strobedelay=0.9*t_dwell strobeoutput=strobeonly
alt_b4  alter param=v_code value=4
tran_b4 tran stop=t_stop errpreset=moderate strobeperiod=t_dwell strobedelay=0.9*t_dwell strobeoutput=strobeonly
alt_b5  alter param=v_code value=5
tran_b5 tran stop=t_stop errpreset=moderate strobeperiod=t_dwell strobedelay=0.9*t_dwell strobeoutput=strobeonly
alt_b6  alter param=v_code value=6
tran_b6 tran stop=t_stop errpreset=moderate strobeperiod=t_dwell strobedelay=0.9*t_dwell strobeoutput=strobeonly
alt_b7  alter param=v_code value=7
tran_b7 tran stop=t_stop errpreset=moderate strobeperiod=t_dwell strobedelay=0.9*t_dwell strobeoutput=strobeonly

save VCTRL VCODE F_INST
saveOptions options save=selected
