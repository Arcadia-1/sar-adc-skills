// =============================================================================
// Process-Independent VCO Testbench — Tuning Curve & K_VCO Extraction
// =============================================================================
// Steps VCTRL across n_pts levels from vctrl_min to vctrl_max and measures
// settled instantaneous oscillation frequency using `va_phase_err_mon.va`.
//
// DUT interface contract (5-pin differential VCO):
//   subckt dut_vco VCTRL OUTP OUTN VDD VSS
// =============================================================================

simulator lang=spectre
global 0

include "models_corner.scs"
include "dut_subckt.scs"
ahdl_include "../../va/va_phase_err_mon.va"

parameters \
    vdd=0.9 \
    vctrl_min=0.15 \
    vctrl_max=0.75 \
    n_pts=7 \
    t_dwell=40n \
    f_init=1.0G \
    temp_c=27

parameters \
    t_stop=n_pts*t_dwell \
    v_step=(vctrl_max-vctrl_min)/(n_pts-1)

VSUP (VDD 0) vsource dc=vdd type=dc
VGND (VSS 0) vsource dc=0   type=dc

// 7-point staircase from vctrl_min to vctrl_max (adapt wave if changing n_pts)
VVCTRL (VCTRL 0) vsource type=pwl wave=[ \
    0               vctrl_min                (1*t_dwell-1n) vctrl_min \
    (1*t_dwell)     (vctrl_min+1*v_step)     (2*t_dwell-1n) (vctrl_min+1*v_step) \
    (2*t_dwell)     (vctrl_min+2*v_step)     (3*t_dwell-1n) (vctrl_min+2*v_step) \
    (3*t_dwell)     (vctrl_min+3*v_step)     (4*t_dwell-1n) (vctrl_min+3*v_step) \
    (4*t_dwell)     (vctrl_min+4*v_step)     (5*t_dwell-1n) (vctrl_min+4*v_step) \
    (5*t_dwell)     (vctrl_min+5*v_step)     (6*t_dwell-1n) (vctrl_min+5*v_step) \
    (6*t_dwell)     vctrl_max                t_stop         vctrl_max ]

// Brief initial kick pulse to guarantee startup of symmetric LC tanks
IKICK (OUTP OUTN) isource type=pulse val0=0 val1=100u delay=0 rise=10p fall=10p width=0.2n

I0    (VCTRL OUTP OUTN VDD VSS) dut_vco
I_MON (OUTP F_INST T_PER) va_phase_err_mon vth=0.5*vdd f_init=f_init

simulatorOptions options psfversion="1.4.0" \
    reltol=1e-4 vabstol=1e-7 iabstol=1e-13 \
    temp=temp_c tnom=27 gmin=1e-12 rforce=1 maxnotes=5 maxwarns=5

// Strobe near end of each dwell window (strobedelay < strobeperiod)
tran tran stop=t_stop errpreset=moderate \
    strobeperiod=t_dwell strobedelay=0.9*t_dwell strobeoutput=strobeonly

save VCTRL F_INST T_PER
saveOptions options save=selected
